.param L_DEVICE=1 W_MIR=5 W_TAIL=10 W_IN=10 W_LOAD=20
+ W_GM=84.8372040812631 W_LOAD2=20 CCOMP=1.85718093697968e-11 IBIAS=5.50756956367589e-05
